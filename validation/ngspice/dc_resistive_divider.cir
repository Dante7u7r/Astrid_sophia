Astryd Sophia external correlation: resistive divider
V1 1 0 DC 12
R1 1 2 2k
R2 2 0 1k
.op
.end
